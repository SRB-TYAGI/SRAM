ADE simulation setup
Run mode: Single Run, Sweeps and Corners
Tests:
  SRAM:SRAM_6T:1: SRAM/SRAM_6T/schematic, simulator spectre
Global variables:
  vdd = 1.8
Corners:
  model folders: /home/buet/cadence/gpdk090_v4.6/models/spectre
  C0: vdd=1.8,1; gpdk090.scs[FF, SS, FS, SF]
